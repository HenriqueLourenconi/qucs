/*
 * RCS Info
 * $Id: disciplines.vams 1825 2011-03-11 20:42:14Z ela $
 *
 */

nature Current
 access=I;
 units="A";
 abstol=1e-12;
endnature

nature Voltage
 access=V;
 units="V";
 abstol=1e-6;
endnature

discipline electrical
 potential Voltage;
 flow      Current;
enddiscipline

nature Temperature
 access=Temp;
 units="C";
 abstol=1e-4;
endnature

nature Power
 access=Pwr;
 units="W";
 abstol=1e-9;
endnature

discipline thermal
 potential Temperature;
 flow      Power;
enddiscipline
